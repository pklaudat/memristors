**********************************************************************************************************
* Pershin and Di Ventra - Current Threshold
***********************************************************************************************************
simulator lang=spectre
include "pershin-current-threshold/memristor.scs"

parameters
+ vmem=1.0
+ method=traponly

VDD2 vcc 0 vsource type=pwl wave=[0 1u 50n 1u 50.01n vmem 100n vmem 100.01n 1u 150n 1u 150.01n -vmem 200n -vmem 200.01n 1u]
VSS2 vss 0 vsource dc=0
XMEMRISTOR vcc vss memristor
