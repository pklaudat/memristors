* HP Memristor SPICE Model Using Biolek Window

* Connections:
* TE:  Top electrode
* BE:  Bottom electrode
* XSV: External connection to plot state variable
*      that is not used otherwise
simulator lang=spectre

parameters Ron=100 Roff=1K x0=0.076 D=16N uv=40F p=7

real stp(real a) {
    return a>0?1.0:0.0
}

real f1(real v1, real i1) {
    return (1-pow((v1-stp(-i1)),(2*p)))
}

real f2(real v1, real v2) {
    return (v1/(Ron*v2 + Roff*(1-v2)))
}

subckt biolek (TE BE XSV)
* * Circuit to determine state variable
    Gx 0 XSV bsource i=(i(Gmem)*Ron*uv*f1(v(XSV),i(Gmem))/pow(D,2))
    Cx XSV 0 capacitor c=1 ic=x0
* * Current source representing memristor
    Gmem TE BE bsource i=f2(v(TE)-v(BE),v(XSV))
ends biolek

* .SUBCKT MEM_BIOLEK TE BE XSV

* * Ron:  Minimum device resistance
* * Roff: Maximum device resistance
* * D:    Width of the thin film
* * uv:   Dopant mobility
* * p:    Parameter for window function
* * x0:   State varaible initial value

* .params Ron=100 Roff=1K x0=.076 D=16N uv=40F p=7

* * Biolek Window Function
* .func f(V1,I1)={1-pow((V1-stp(-I1)),(2*p))}

* * Memristor I-V Relationship
* .func IVRel(V1,V2) = V1/(Ron*V2 + Roff*(1-V2))

* * Circuit to determine state variable
* Gx 0 XSV value={I(Gmem)*Ron*uv*f(V(XSV,0),I(Gmem))/pow(D,2)}
* Cx XSV 0 {1}
* .ic V(XSV) = x0

* * Current source representing memristor
* Gmem TE BE value={IVRel(V(TE,BE),V(XSV,0))}

* .ENDS MEM_BIOLEK
