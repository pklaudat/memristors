**********************************************************************************************************
* Pershin and Di Ventra - Current Threshold
***********************************************************************************************************
simulator lang=spectre
include "model/memristor.scs"

parameters
+ vmem=-30u
+ method=traponly
+ temp_celsius=26.85

IDD vcc 0 isource type=pwl wave=[0 1u 50n 1u 50.01n vmem 100n vmem 100.01n 1u 150n 1u 150.01n -vmem 200n -vmem 200.01n 1u]
*VSS2 vss 0 vsource dc=0
* IDD vcc 0 isource type=pwl wave=[0 vmem 50n vmem 50.01 1u]
XMEMRISTOR vcc 0 memristor

highVoltageOptions options highvoltage=yes bin_relref=yes
simulOptions options save=all \
    tnom=25 gmin=1p rforce=1 maxnotes=5 maxwarns=5 \
    subcktprobelvl=3 saveahdlvars=all \
    temp=(temp_celsius)

transweep sweep param=vmem start=-25u stop=-45u step=-2.5u {
    transim tran start=0.01p step=1f stop=250n method=method
}

simulator lang=spice
.meas tsw0 when v(XMEMRISTOR:x)='30.0e3'
