simulator lang=spectre

include "pershin-current-threshold/imply/imply.scs"

parameters
+ vcond=-0.8
+ vclear=1.0
+ vset=-1.2
+ vlow=-0.1u
+ method=traponly
* vset > vcond
* vset - vcond < vclear
*VCLEAR (bitline 0) vsource dc=vclear
*VSET (set 0) vsource type=pwl wave=[0 vlow 5n vlow 5.01n vset 10n vset 10.01n vlow 15n vlow 15.01n -vset 20n -vset 20.01n vlow]
VSET (set 0) vsource type=pwl wave=[0 vlow 5n vlow 5.01n vset 10n vset 10.01n vlow 15n vlow 15.01n -vset 20n -vset 20.01n vlow 25n vlow 25.01n vset 30n vset 30.01n vlow]
VCOND (cond 0) vsource type=pwl wave=[0 vlow 5n vlow 5.01n vcond 10n vcond 10.01n vlow 15n vlow 15.01n -vcond 20n -vcond 20.01n vlow 25n vlow 25.01n vset 30n vset 30.01n vlow]
IMPLY (cond set bitline) imply rg=6k

tranop options save=all current=all
transim tran start=0.01p step=1f stop=50n
