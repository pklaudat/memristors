simulator lang=spectre
include "../model/memristor.scs"

subckt imply (vcond vset bitline)
parameters
+ rg=15k
XP (vcond bitline) memristor
XQ (vset bitline) memristor
RG (bitline 0) resistor r=rg
ends imply
