************************************************************************************
************************************************************************************
** Title:  LLG_solver.scs
** Adapted by: Paulo Klaudat, Laboratório de Prototipação e Teste @ UFRGS
** Author: Jongyeon Kim, VLSI Research Lab @ UMN
** Email:  pauloklaudat@gmail.com
********************************************************************************************************
** This library includes all sub-circuits, such as Heat Diffusion, the LLG Solver and the TMR module.
** The voltage accross the MTJ is used to compute a dynamic current and the memristance.
********************************************************************************************************
simulator lang= spectre
******* Libraries ***********************
include "LLG_solver.scs"
include "HeatDF.scs"
include "Resistor.scs"
*****************************************

subckt MTJ (e1 e2)
parameters lx=65n ly=130n lz=1.8n Ms0=1075 P0=0.715 alpha=0.01 Tmp0=300 RA0=5.4 MA=0.0 ini=1
XRA (ex e2 Mx My Mz Tmp thi) RA lx=lx ly=ly P0=P0 RA0=RA0 MA=MA
XLLG (Mx My Mz Is Ias Tmp thi) LLG lx=lx ly=ly lz=lz Ms0=Ms0 P0=P0 alpha=alpha MA=MA ini=ini
XHD (Ihd Tmp) HD x=lx ly=ly lz=lz Tmp0=Tmp0

*** Internal top electrode of MTJ ***************
Ve1 (e1 ex) bsource v=0

*** Asymetry of write current ************************
*** positive bias:Ias=Iatp, negative bias:Ias=Ipta ***
*** Iatp will generate more spin current. ************
parameters Iatp=1
parameters Ipta=1/1.5
E_Ias (Ias 0) bsource v=(1+(v(e1)-v(e2))/abs(v(e1)-v(e2)))*(Iatp-Ipta)/2+Ipta
G_Imtj1 (0 Is) bsource i=-I(Ve1) //***charge current passing through MTJ
G_Imtj2 (0 Ihd) bsource i=-I(Ve1) //*** Imtj is fed to llg and hd subckt
ends MTJ
