************************************************************************************
************************************************************************************
** Title:  HeatDF.scs
** Adapted by: Paulo Klaudat, Laboratório de Prototipação e Teste @ UFRGS
** Author: Jongyeon Kim, VLSI Research Lab @ UMN
** Email:  pauloklaudat@gmail.com
************************************************************************************
** This module reproduces the joule heating effect in MTJ, increasing the internal
** temperature. This effect causes changes in Saturation Magnetization Ms and also
** in the Polarization property. The node Tmp is fed back to the LLG module and the
** TMR module given by Resistor.scs
************************************************************************************

simulator lang=spectre

subckt HD (Ihd Tmp)
parameters lx=65n ly=130n lz=1.8n Tmp0=300
*** Unit length for diffusion ******************
parameters dL=lz/7*(pow(10,7))

*** Volumetric specific heat capacity **********
*** f:Fe, o:MgO ********************************
parameters Cvf=3.54
parameters Cvo=0.004

*** Heat conductivity **************************
parameters Kf=0.802
parameters Ko=0.6

*** RC conversion for diffusion equation *******
parameters Cf=Cvf
parameters Co=Cvo
parameters Rf=dL*dL/Kf
parameters Ro=dL*dL/Ko

********************
parameters rho=1*pow(10,-5)
**********************************

*** Head diffusion by distributed RC model *****
Rl01 (Tmp l1) resistor r=Rf
Rl12 (l1 l2) resistor r=Rf
Rl23 (l2 l3) resistor r=Rf
Rl34 (l3 l4) resistor r=Rf
Rl45 (l4 l5) resistor r=Rf
Rl56 (l5 l6) resistor r=Rf
Rl67 (l6 l7) resistor r=Rf
Vl (l7 0) bsource v=Tmp0

Cl0 (Tmp 0) capacitor c=Cf
Cl1 (l1 0) capacitor c=Cf
Cl2 (l2 0) capacitor c=Cf
Cl3 (l3 0) capacitor c=Cf
Cl4 (l4 0) capacitor c=Cf
Cl5 (l5 0) capacitor c=Cf
Cl6 (l6 0) capacitor c=Cf
ic Tmp = Tmp0
ic l1 = Tmp0
ic l2 = Tmp0
ic l3 = Tmp0
ic l4 = Tmp0
ic l5 = Tmp0
ic l6 = Tmp0

R_Ihd (Ihd 0) resistor r=1
G_Tmp (0 Tmp) bsource i=rho*pow((v(Ihd)/(lx*ly*pow(10,4))),2)/Kf

Rm01 (Tmp m1) resistor r=Ro
Rm02 (m1 m2) resistor r=Ro
Rr01 (m2 r1) resistor r=Rf
Rr12 (r1 r2) resistor r=Rf
Rr23 (r2 r3) resistor r=Rf
Rr34 (r3 r4) resistor r=Rf
Rr45 (r4 r5) resistor r=Rf
Rr56 (r5 r6) resistor r=Rf
Rr67 (r6 r7) resistor r=Rf
Vr (r7 0) bsource v=Tmp0

Cm0 (Tmp 0) capacitor c=Co
Cm1 (m1 0) capacitor c=Co
Cr0 (m2 0) capacitor c=Cf
Cr1 (r1 0) capacitor c=Cf
Cr2 (r2 0) capacitor c=Cf
Cr3 (r3 0) capacitor c=Cf
Cr4 (r4 0) capacitor c=Cf
Cr5 (r5 0) capacitor c=Cf
Cr6 (r6 0) capacitor c=Cf
ic m1 = Tmp0
ic m2 = Tmp0
ic r1 = Tmp0
ic r2 = Tmp0
ic r3 = Tmp0
ic r4 = Tmp0
ic r5 = Tmp0
ic r6 = Tmp0

ends HD
